* combined sim for 500kHz
Vin N001 0 AC 1 Rser=50
C1 N001 0 6.737n
C2 N002 N001 706.2p
L1 N002 N001 19.97µ
C3 N002 0 10.90n
C4 Vout1 N002 1.989n
L2 Vout1 N002 16.53µ
C5 Vout1 0 5.709n
RL Vout1 0 50
Vin1 N003 0 AC 1 Rser=50
C6 N003 0 6.8n
C7 N004 N003 680p
L3 N004 N003 22µ Rser=0.135
C8 N004 0 10n
C9 Vout2 N004 2n
L4 Vout2 N004 16µ Rser=0.0345
C10 Vout2 0 5.6n
RL1 Vout2 0 50
Vin2 P001 0 AC 1 Rser=50
Cp1 P001 0 6.8e-09
Cp2 P002 P001 4.7e-10
Lp1 P002 P001 22µ Rser=0.135
Cp3 P002 0 1e-08
Cp4 Vout3 P002 2.2e-09
Lp2 Vout3 P002 16µ Rser=0.0345
Cp5 Vout3 0 4.7e-09
RLp Vout3 0 50
.ac dec 100 200000 2000000
.end
