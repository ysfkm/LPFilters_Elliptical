* combined sim for 2kHz
Vin N001 0 AC 1 Rser=50
C1 N001 0 1.684µ
C2 N002 N001 176.5n
L1 N002 N001 4.993m
C3 N002 0 2.724µ
C4 Vout1 N002 497.2n
L2 Vout1 N002 4.132m
C5 Vout1 0 1.427µ
RL Vout1 0 50
Vin1 N003 0 AC 1 Rser=50
C6 N003 0 1.5µ
C7 N004 N003 180n
L3 N004 N003 4.7m Rser=12.5
C8 N004 0 3.3µ
C9 Vout2 N004 470n
L4 Vout2 N004 4m Rser=12.35
C10 Vout2 0 1.5µ
RL1 Vout2 0 50
Vin2 P001 0 AC 1 Rser=50
Cp1 P001 0 1e-06
Cp2 P002 P001 2.2e-07
Lp1 P002 P001 4.7m Rser=12.5
Cp3 P002 0 2.2e-06
Cp4 Vout3 P002 4.7e-07
Lp2 Vout3 P002 4m Rser=12.35
Cp5 Vout3 0 1e-06
RLp Vout3 0 50
.ac dec 100 1000 10000
.end
